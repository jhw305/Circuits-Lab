** Profile: "SCHEMATIC1-sim"  [ C:\Users\johnm\Documents\repos\170\Circuits-Lab\Spring2017\Lab8\spice_simulation\pspice\DLatch-PSpiceFiles\SCHEMATIC1\sim.sim ]

** Creating circuit file "sim.cir"
** WARNING: THIS AUTOMATICALLY GENERATED FILE MAY BE OVERWRITTEN BY SUBSEQUENT SIMULATIONS

*Libraries:
* Profile Libraries :
* Local Libraries :
.LIB "../../../dlatch-pspicefiles/dlatch.lib"
* From [PSPICE NETLIST] section of C:\Users\johnm\Documents\repos\cdssetup\OrCAD_PSpice\17.2.0\PSpice.ini file:
.lib "nomd.lib"

*Analysis directives:
.TRAN  0 1000ns 0
.OPTIONS ADVCONV
.PROBE64 V(alias(*)) I(alias(*)) W(alias(*)) D(alias(*)) NOISE(alias(*))
.INC "..\SCHEMATIC1.net"

.END
